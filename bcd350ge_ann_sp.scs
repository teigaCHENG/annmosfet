// according to HHGrace bcd350ge pdk
// Example of the Annular MOSFET
section ann
inline subckt ann_mac (D G S B)
parameters
+toxnenh5=0.00E+000
+toxpenh5=0.00E+000
+lintnenh5=0.00E+000
+lintpenh5=0.00E+000
+vth0nenh5=1.0150E+000
+vth0penh5=9.9930E-001
+vsatnenh5=9.70E-001
+vsatpenh5=1.00E+000
+rcjnenh5=1.00E+000
+rcjpenh5=1.00E+000
+rcjswnenh5=1.00E+000
+rcjswpenh5=1.00E+000
+rcjswgnenh5=1.00E+000
+rcjswgpenh5=1.00E+000
+rcgonenh5=1.00E+000
+rcgopenh5=1.00E+000
+u0nenh5=1.03E+000
+u0penh5=1.00E+000
+nlxnenh5=0.00E+000
+dvt0penh5=0.00E+000
+k3nenh5=-1.35E+001
+k3penh5=0.00E+000
+wintnenh5=-2.80E-008
+wintpenh5=0.00E+000
+pvth0nenh5=-1.90E-015
+pvth0penh5=0.00E+000
+pvsatnenh5=-2.0202E-010
+pvsatpenh5=0.00E+000
+numsigma_vth0mis_nenh5=0.00E+000
+numsigma_vsatmis_nenh5=0.00E+000
+numsigma_vthmis_penh5=0.00E+000
+numsigma_dlmis_penh5=0.00E+000
+numsigma_dwmis_penh5=0.00E+000
+numsigma_toxmis_penh5=0.00E+000
+numsigma_citmis_penh5=4.60E+001

+l=5.00E-007 w=1.00E-006 m=1 misfactor=1 avth0nenh5=0.0133 avsatnenh5=0.0224
+dtemp=0.00E+000 exp=5.0E-1
+ad=2.50E-013
+as=2.61E-012
+pd=1.00000E-006
+ps=4.80000E-006
//+nrd=0.125
//+nrs=0.25

+lef=(l)
+wef=(w)
+geo_area=(1/((m*lef*wef*1e12)**exp)) geo_l=(1/sqrt(count*wef*1e6)) geo_w=(1/sqrt(lef*1e6)) vth0mis_nenh5=(avth0nenh5*geo_area*numsigma_vth0mis_nenh5*misfactor) vsatmis_nenh5=(1+avsatnenh5*geo_area*numsigma_vsatmis_nenh5*misfactor)

M1 D G S B ann w=w l=l ad=ad as=as pd=pd ps=ps m=1.443 //nrd=nrd nrs=nrs
M2 D G S B ann w=w l=l ad=ad as=as pd=pd ps=ps m=1.443 //nrd=nrd nrs=nrs
M3 D G S B ann w=w l=l ad=ad as=as pd=pd ps=ps m=1.443 //nrd=nrd nrs=nrs
M4 D G S B ann w=w l=l ad=ad as=as pd=pd ps=ps m=1.443 //nrd=nrd nrs=nrs

//M1 D G S B ann w=w l=l ad=ad as=as pd=pd ps=ps m=5.772 //nrd=nrd nrs=nrs 4x mos multiplier

model ann bsim3v3 type=n
+version=3.20
+binunit=2.00
+mobmod=1.00E+000
+capmod=3.00
+nqsmod=0.00
+minr=1.00E-010
+tnom=2.50E+001
+tox=(toxnenh5+(1.611e-008))
+wint=(wintnenh5+2.025919e-007)
+lint=lintnenh5+(7.03836e-008)
+dlc=-3.44E-008
+dwc=0.00E+000
+hdif=2.50E-007
+ldif=0.00E+000
+xl=0.00E+000
+xw=0.00E+000
+xj=1.50E-007
+ngate=1.00E+023
+ll=0.00E+000
+wl=0.00E+000
+lln=1.00E+000
+wln=1.00E+000
+lw=0.00E+000
+ww=-3.52E-014
+lwn=1.00E+000
+wwn=1.00E+000
+lwl=0.00E+000
+wwl=-1.51E-020
+llc=0.00E+000
+wlc=0.00E+000
+lwc=0.00E+000
+wwc=0.00E+000
+lwlc=0.00E+000
+wwlc=0.00E+000
+xpart=0.00E+000
+vth0=(vth0nenh5*(0.62))+vth0mis_nenh5
+k1=6.87E-001
+k2=8.97E-002
+wk2=8.15E-009
+k3=k3nenh5+19.55
+k3b=-8.06E+000
+nlx=nlxnenh5+2.453325e-007
+w0=2.50E-006
+dvt0=7.18E+000
+dvt1=8.39E-001
+dvt2=-5.15E-002
+dvt0w=3.40E-001
+dvt1w=5.94E+005
+dvt2w=-1.75E+000
+nch=1.70E+017
+voff=-1.01E-001
+nfactor=7.58E-001
+cdsc=2.40E-004
+cdscb=0.00E+000
+cdscd=0.00E+000
+cit=0.00E+000
+alpha0=-1.60E-007
+alpha1=9.16E+000
+beta0=3.34E+001
+eta0=6.33E-002
+etab=-1.68E-002
+dsub=5.93E-001
+u0=u0nenh5*0.052264
+ua=5.97E-010
+ub=1.62E-018
+uc=6.07E-011
+prwg=-1.11E-002
+wprwg=-1.67E-008
+prwb=0.00E+000
+wr=1.00E+000
+rdsw=9.51E+002
+a0=1.46E+000
+ags=1.16E-001
+a1=0.00E+000
+a2=1.00E+000
+b0=1.10E-007
+b1=0.00E+000
+vsat=vsatnenh5*(95200)*vsatmis_nenh5
+keta=5.64E-003
+delta=1.00E-002
+dwg=-3.00E-009
+dwb=9.00E-009
+pclm=2.95E+000
+ppclm=3.06E-013
+pdiblc1=7.16E-002
+pdiblc2=1.59E-003
+pdiblcb=-2.78E-005
+drout=7.90E-001
+pvag=8.21E-001
+pscbe1=2.90E+008
+pscbe2=2.40E-008
+elm=5.00E+000
+pvth0=pvth0nenh5+0
+pvsat=pvsatnenh5+0
+clc=1.00E-007
+cle=6.00E-001
+acde=8.40E-001
+moin=4.00E+000
+vfbcv=-1.00E+000
+noff=1.00E+000
+voffcv=-5.00E-001
+cgbo=0.00E+000
+cgso=rcgonenh5*(1.1e-010)
+cgdo=rcgonenh5*(1.1e-010)
+cgdl=rcgonenh5*(7e-011)
+cgsl=rcgonenh5*(7e-011)
+cf=0.00E+000
+ckappa=6.00E-001
+kt1=-4.07E-001
+kt1l=6.61E-009
+kt2=-4.09E-002
+ute=-1.58E+000
+wute=6.00E-008
+ua1=1.33E-009
+ub1=-2.70E-018
+pub1=1.00E-031
+uc1=-1.51E-010
+prt=4.00E+002
+at=3.30E+004
+rsh=0.00E+000
+js=4.85E-006
+jsw=3.20E-011
+cj=rcjnenh5*0.000615
+mj=4.75E-001
+cjsw=rcjswnenh5*1.33e-010
+mjsw=1.44E-001
+cjswg=rcjswgnenh5*2.04e-010
+mjswg=4.30E-001
+pb=1.02E+000
+pbsw=3.90E-001
+pbswg=1.00E+000
+xti=3.00E+000
+n=1.30E+000
+noimod=2.00E+000
+noia=1.00E+021
+noib=3.02E+003
+noic=-1.00E-013
+ef=1.06E+000
+em=4.00E+006
+tlev=1.00E+000
+tlevc=1.00E+000

ends ann_mac
endsection ann
