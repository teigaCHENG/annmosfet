// example of an annular mosfet version one
// Comparing with ann_sp_v0 model
// the area of the source and drain is identical with version zero
// the perimeter of the source and drain is only considering the channel width component
// without considering the isosceles of the trapezoids in the device
// BSIM4 model
// tsmc025bcd

section ann
inline subckt ann_mac (D G S B)
parameters l=5.00E-007 w=1.00E-006 multi=1 nf=1 scale=1 sigma=1
+dmcg=5.00E-007 dmci=5.00E-007 xw=0
+ad=2.50E-013
+as=3.00E-012
+pd=1.00E-006
+ps=6.00E-006
+nrd=0.125 nrs=0.25
+sa=1.00E-006 sb=0 sd=0 sca=0 scb=0 scc=0
+mismatchflag=1

+dagsn_5=0.00E+000
+dwagsn_5=0.00E+000
+dlketan_5=0.00E+000
+dpdiblc2n_5=0.00E+000
+dlpdiblc2n_5=0.00E+000
+dwpdiblc2n_5=0.00E+000
+dppdiblc2n_5=0.00E+000
+cgon_5=2.03E-010
+cgln_5=1.07E-011
+cfn_5=0.00E+000
+cjn_5=9.83E-004
+cjswn_5=2.01E-010
+cjswgn_5=2.59E-010
***mismatch***
+lef=((l)*scale)
+wef=((w/nf)*scale)
+temp1=agauss(0,1,1) temp2=agauss(0,1,1) temp3=agauss(0,1,1) temp4=agauss(0,1,1) temp5=agauss(0,1,1)
+mis_a_1=0.005 mis_a_2=0 mis_a_3=0
+mis_b_1=0.004 mis_b_2=0.1 mis_b_3=0.1
+mis_c_1=1 mis_c_2=0 mis_c_3=0
+mis_d_1=6.83e-04 mis_d_2=0 mis_d_3=0
+mis_e_1=0.005 mis_e_2=-0.3 mis_e_3=0.2 e_limit=2
+a=(mis_a_1*pwr(lef*1e6,mis_a_2)*pwr(wef*1e6,mis_a_3))
+b=(mis_b_1*pwr(lef*1e6,mis_b_2)*pwr(wef*1e6,mis_b_3))
+c=(mis_c_1*pwr(lef*1e6,mis_c_2)*pwr(wef*1e6,mis_c_3))
+d=(mis_d_1*pwr(lef*1e6,mis_d_2)*pwr(wef*1e6,mis_d_3))
+e=(mis_e_1*pwr(lef*1e6,mis_e_2)*pwr(wef*1e6,mis_e_3))
+fac1=(temp1)
+fac2=(temp2)
+fac3=(temp3)
+fac4=(temp4)
+fac5=(c*temp4+sqrt(1-c*c)*temp5)
+geo_fac =(1/sqrt(multi*nf*lef*wef*1e12)*mismatchflag*sigma)
+toxmisn=(d*geo_fac*toxn*fac1)
+dxlmisn=(b*geo_fac*lef*fac2)
+dxwmisn=(-b*geo_fac*wef*fac3)
+dvthmisn=(a*geo_fac*fac4)
+fu0misn=(min(e_limit,1+e*geo_fac*fac5))

M1 D G S B ann w=w l=l ad=ad as=as pd=pd ps=ps nrd=nrd nrs=nrs m=1.443 nf=nf sa=sa sb=sb sd=sd sca=sca scb=scb scc=scc
M2 D G S B ann w=w l=l ad=ad as=as pd=pd ps=ps nrd=nrd nrs=nrs m=1.443 nf=nf sa=sa sb=sb sd=sd sca=sca scb=scb scc=scc
M3 D G S B ann w=w l=l ad=ad as=as pd=pd ps=ps nrd=nrd nrs=nrs m=1.443 nf=nf sa=sa sb=sb sd=sd sca=sca scb=scb scc=scc
M4 D G S B ann w=w l=l ad=ad as=as pd=pd ps=ps nrd=nrd nrs=nrs m=1.443 nf=nf sa=sa sb=sb sd=sd sca=sca scb=scb scc=scc

model ann bsim4
//{
+type =n
+lmax =8.20E-007
+wmin =3.00E-007
+wmax =1.17E-006
+version =4.50E+000
+binunit =2.00E+000
+paramchk =1.00E+000
+mobmod     =0.00E+000
+capmod     =2.00E+000
+igcmod     =0.00E+000
+igbmod     =0.00E+000
+diomod     =1.00E+000
+rdsmod     =0.00E+000
+rbodymod   =0.00E+000
+rgatemod   =0.00E+000
+permod     =1.00E+000
+acnqsmod   =0.00E+000
+trnqsmod   =0.00E+000
+tempmod    =0.00E+000
+tnom       =2.50E+001
+toxe       =1.27E-008
+toxm       =1.27E-008
+dtox       =7.20E-010
+epsrox     =3.90E+000
+wint       =0.00E+000
+lint       =7.60E-008
+ll         =0.00E+000
+wl         =0.00E+000
+lln        =1.00E+000
+wln        =1.00E+000
+lw         =0.00E+000
+ww         =0.00E+000
+lwn        =1.00E+000
+wwn        =1.00E+000
+lwl        =0.00E+000
+wwl        =0.00E+000
+wwc        =0.00E+000
+xl         =1.00E-008
+xw         =3.00E-008
+dlc        =6.53E-008
+dwc        =0.00E+000
+xpart      =1.00E+000
+toxref     =3.00E-009
+dlcig      =6.25E-009
+vth0       =8.63E-001
+lvth0      =1.27E-008
+kvth0    =-2.50E-009
+pkvth0   =0.00E+000
+wkvth0   =-5.50E-008
+lkvth0   =1.00E-007
+wvth0      =-2.97E-008
+pvth0      =5.87E-015
+k1         =1.00E+000
+k2         =2.28E-002
+lk2        =-9.44E-009
+wk2        =2.11E-009
+pk2        =3.17E-015
+k3         =0.00E+000
+k3b        =1.11E+000
+w0         =0.00E+000
+dvt0       =3.12E+000
+dvt1       =2.81E-001
+dvt2       =-2.41E-002
+dvt0w      =0.00E+000
+dvt1w      =0.00E+000
+dvt2w      =0.00E+000
+dsub       =5.00E-001
+minv       =-1.50E-001
+voffl      =0.00E+000
+dvtp0      =7.00E-008
+dvtp1      =9.40E-002
+lpe0       =3.88E-008
+lpeb       =1.57E-008
+xj         =1.50E-007
+ngate      =1.10E+020
+ndep       =2.49E+017
+nsd        =1.00E+020
+phin       =0.00E+000
+cdsc       =0.00E+000
+cdscb      =0.00E+000
+cdscd      =0.00E+000
+cit        =2.24E-004
+lcit       =-9.11E-011
+wcit       =6.86E-011
+pcit       =2.73E-017
+voff       =-1.41E-001
+lvoff      =-4.92E-009
+wvoff      =-4.37E-009
+pvoff      =1.33E-015
+nfactor    =5.00E-001
+eta0       =2.60E-001
+leta0      =-4.69E-009
+weta0      =-5.91E-008
+peta0      =5.63E-015
+etab       =-2.86E-001
+wetab      =4.70E-008
+ud         =0.00E+000
+lud        =0.00E+000
+wud        =0.00E+000
+pud        =0.00E+000
+u0         =8.34E-002
+ku0      =-3.10E-008
+tku0     =0.00E+000
+pku0     =0.00E+000
+wku0     =6.00E-007
+lku0     =0.00E+000
+lu0        =0.00E+000
+wu0        =0.00E+000
+pu0        =-0.00E+000
+ua         =-4.51E-009
+lua        =2.85E-015
+wua        =1.09E-015
+pua        =-4.27E-022
+ub         =6.11E-018
+lub        =-3.14E-024
+wub        =-1.08E-024
+pub        =3.57E-031
+uc         =1.34E-010
+luc        =-5.46E-017
+wuc        =-1.96E-018
+puc        =-9.52E-024
+vsat       =7.71E+004
+lvsat      =-6.14E-004
+kvsat    =2.60E-001
+wvsat      =4.52E-003
+pvsat      =-7.49E-010
+a0         =1.61E+000
+la0        =-8.11E-007
+wa0        =6.99E-008
+pa0        =-5.93E-014
+ags        =2.36E-001
+wags       =-1.90E-009
+a1         =0.00E+000
+a2         =9.90E-001
+b0         =0.00E+000
+b1         =0.00E+000
+keta       =-6.05E-002
+lketa      =5.88E-009
+wketa      =1.69E-008
+pketa      =-9.04E-015
+dwg        =0.00E+000
+dwb        =0.00E+000
+pclm       =3.45E-002
+lpclm      =5.68E-008
+wpclm      =2.51E-008
+ppclm      =-1.70E-014
+pdiblc1    =0.00E+000
+pdiblc2    =1.74E-003
+lpdiblc2   =-3.70E-010
+wpdiblc2   =-7.42E-010
+ppdiblc2   =4.44E-016
+pdiblcb    =0.00E+000
+drout      =5.60E-001
+pvag       =0.00E+000
+delta      =2.00E-002
+pscbe1     =3.90E+008
+pscbe2     =1.00E-008
+fprout     =0.00E+000
+pdits      =0.00E+000
+pditsd     =0.00E+000
+pditsl     =0.00E+000
+rsh        =4.68E+000
+rdsw       =6.41E+002
+prwg       =0.00E+000
+prwb       =0.00E+000
+wr         =1.00E+000
+alpha0     =0.00E+000
+alpha1     =8.40E+000
+lalpha1    =1.86E-006
+walpha1    =-1.69E-006
+palpha1    =-5.33E-013
+beta0      =3.51E+001
+lbeta0     =-1.92E-007
+wbeta0     =-1.84E-006
+pbeta0     =-2.91E-013
+agidl      =-2.31E-013
+lagidl     =2.49E-019
+wagidl     =-1.62E-020
+pagidl     =-3.71E-027
+bgidl      =1.65E+008
+cgidl      =5.00E-001
+egidl      =2.60E-001
+aigbacc    =1.21E-002
+bigbacc    =6.54E-003
+cigbacc    =2.81E-001
+nigbacc    =4.05E+000
+aigbinv    =3.50E-001
+bigbinv    =3.00E-002
+cigbinv    =6.00E-003
+eigbinv    =1.10E+000
+nigbinv    =1.00E+000
+aigc       =1.27E-002
+bigc       =1.64E-003
+cigc       =1.52E-005
+aigsd      =1.23E-002
+bigsd      =1.57E-003
+cigsd      =3.93E-020
+nigc       =1.00E+000
+poxedge    =1.00E+000
+pigcd      =2.17E+000
+ntox       =1.00E+000
+xrcrg1     =1.20E+001
+xrcrg2     =1.00E+000
+cgso       =2.03E-010
+cgdo       =2.03E-010
+cgbo       =0.00E+000
+cgdl       =1.07E-011
+cgsl       =1.07E-011
+clc        =1.00E-007
+cle        =6.00E-001
+cf         =0.00E+000
+ckappas    =6.00E-001
+ckappad    =6.00E-001
+acde       =3.00E-001
+moin       =9.70E+000
+noff       =2.95E+000
+voffcv     =-6.55E-002
+tvoff      =1.69E-003
+ltvoff     =-5.15E-010
+wtvoff     =3.78E-010
+ptvoff     =-2.01E-016
+kt1        =-4.36E-001
+lkt1       =2.14E-008
+wkt1       =2.20E-008
+pkt1       =-1.03E-014
+kt1l       =0.00E+000
+kt2        =-6.77E-002
+ute        =-1.50E+000
+ua1        =7.55E-010
+lua1       =1.68E-016
+wua1       =1.56E-016
+pua1       =-3.09E-022
+ub1        =-9.68E-019
+lub1       =4.50E-025
+wub1       =-2.94E-025
+pub1       =3.39E-031
+uc1        =5.77E-011
+prt        =0.00E+000
+at         =6.36E+002
+lat        =7.33E-003
+wat        =-3.12E-003
+pat        =2.56E-009
+fnoimod    =1.00E+000
+tnoimod    =0.00E+000
+em         =1.19E+010
+ef         =9.00E-001
+noia       =9.00E+040
+noib       =5.00E+024
+noic       =1.50E+004
+lintnoi    =-1.00E-007
+jss        =8.14E-007
+jsd        =8.14E-007
+jsws       =3.07E-012
+jswd       =3.07E-012
+jswgs      =2.50E-012
+jswgd      =2.50E-012
+njs        =1.02E+000
+njd        =1.02E+000
+ijthsfwd   =1.00E-002
+ijthdfwd   =1.00E-002
+ijthsrev   =1.00E-002
+ijthdrev   =1.00E-002
+bvs        =9.30E+000
+bvd        =9.30E+000
+xjbvs      =1.00E+000
+xjbvd      =1.00E+000
+jtsswgs    =1.00E-013
+jtsswgd    =1.00E-013
+njtsswg    =1.30E+001
+xtsswgs    =6.10E-001
+xtsswgd    =6.10E-001
+tnjtsswg   =1.00E+000
+vtsswgs    =2.00E+001
+vtsswgd    =2.00E+001
+pbs        =7.41E-001
+pbd        =7.41E-001
+cjs        =9.83E-004
+cjd        =9.83E-004
+mjs        =3.25E-001
+mjd        =3.25E-001
+pbsws      =3.43E-001
+pbswd      =3.43E-001
+cjsws      =2.01E-010
+cjswd      =2.01E-010
+mjsws      =1.03E-001
+mjswd      =1.03E-001
+pbswgs     =5.65E-001
+pbswgd     =5.65E-001
+cjswgs     =2.59E-010
+cjswgd     =2.59E-010
+mjswgs     =2.39E-001
+mjswgd     =2.39E-001
+tpb        =1.50E-003
+tcj        =8.00E-004
+tpbsw      =1.27E-003
+tcjsw      =4.92E-004
+tpbswg     =2.30E-003
+tcjswg     =1.42E-003
+xtis       =3.00E+000
+xtid       =3.00E+000
+dmcg       =2.35E-007
+dmci       =2.35E-007
+dmdg       =0.00E+000
+dmcgt      =0.00E+000
+dwj        =0.00E+000
+xgw        =0.00E+000
+xgl        =0.00E+000
+gbmin      =1.00E-012
+rbpb       =5.00E+001
+rbpd       =5.00E+001
+rbps       =5.00E+001
+rbdb       =5.00E+001
+rbsb       =5.00E+001
+ngcon      =1.00E+000
+rshg     =3.93E+000
+saref    =1.00E-005
+sbref    =1.00E-005
+llodvth  =1.00E+000
+wlodvth  =1.00E+000
+wlod     =0.00E+000
+steta0   =0.00E+000
+lodeta0  =1.00E+000
+stk2     =-8.00E-010
+lodk2    =1.00E+000
+llodku0  =1.00E+000
+wlodku0  =1.00E+000
+wpemod   =1.00E+000
+scref    =1.00E-006
+web      =-9.50E+002
+wec      =-0.00E+000
+kvth0we  =1.00E-002
+pkvth0we =-3.50E-016
+wkvth0we =5.00E-010
+lkvth0we =2.90E-009
+ku0we    =-2.50E-003
+pku0we   =2.00E-018
+wku0we   =0.00E+000
+lku0we   =-1.50E-009
+k2we     =1.85E-003
+pk2we    =-3.50E-016
+lk2we    =1.80E-009
+wk2we    =2.00E-010
//	}
ends ann_mac
endsection ann
